XYCE-generated Netlist file copy:  TIME='07:14:19 AM' DATE='Mar 26, 2026'
*Original Netlist Title:

** OpenS Generated Netlist

* Subcircuits
.subckt h_bridge GND P1 P2 VIN en_1_i en_2_i
.model DRIVER npy MODULE=controller_hbridge CLASS=Controller PYTHONPATH=/Users/rennekef/Documents/SchematicEntry/backup/tests/grid-tie/grid-tie-lib/h_bridge
.model BOOT_DIODE D (IS=1e-14 N=1 RS=0.1 CJO=1p M=0.5 TT=1n)
.model POWER_MOS NMOS (LEVEL=1 VTO=2.5 KP=0.5 LAMBDA=0.02 CGSO=100p CGDO=10p CBD=50p)
C1 BOOT1 P1 1u
C2 BOOT2 P2 1u
C3 BOOT1 GND 10p
C4 BOOT2 GND 10p
D1 VHIGH_VDD BOOT1 BOOT_DIODE
D2 VHIGH_VDD BOOT2 BOOT_DIODE
M1 VHIGH_VDD H1 P1 P1 POWER_MOS L=1u W=10u m=1
M2 P1 L1 GND GND POWER_MOS L=1u W=10u m=1
M3 VHIGH_VDD H2 P2 P2 POWER_MOS L=1u W=10u m=1
M4 P2 L2 GND GND POWER_MOS L=1u W=10u m=1
N1 VHIGH_VDD N_1 N_2 en_1_i en_2_i N_3 N_4 GND L1 L2 BOOT1 P2 P1 BOOT2 H2 H1 DRIVER
R1 VIN VHIGH_VDD 0.1
.ends

* Main Circuit

*.preprocess addresistors nodcpath 1G
*Xyce:  ".PREPROCESS ADDRESISTORS" statement automatically commented out in netlist copy.
.model CONTROLLER_HERIC npy MODULE=controller CLASS=Controller PYTHONPATH=/Users/rennekef/Documents/SchematicEntry/backup/tests/grid-tie/grid-tie-lib/heric_inverter
C1 N_2 VSS 10p
C2 VS1 VSS 10p
C3 VS2 VSS 10p
C4 N_1 VSS 10p
L1 N_5 int_1 4m IC=0
R1_ser int_1 N_3 0.01
N1 VDD_3V3 N_6 N_7 N_8 I_MEAS N_9 N_10 N_11 VSS N_12 N_13 N_14 VS2 N_15 N_16 VS1 CONTROLLER_HERIC
R1 I_MEAS VSS 100
R2 VIN_350VDC N_1 0.01
LP1 N_4 N_2 1u
LS1 I_MEAS VSS 20m
K1 LP1 LS1 0.99
V1 N_3 N_4 dc 0 ac 0
* Skipping X2: No template
X_3 VSS N_5 N_2 N_1 VS1 VS2 h_bridge
* --- Stimuli from stimuli.json ---
V_STIM_1_VIN_350VDC VIN_350VDC 0 350
V_STIM_2_VSS VSS 0 0
V_STIM_3_VDD_3V3 VDD_3V3 0 3.3
* ----------------------------------------
.tran 1n 500u
.print tran v(*)

*XYCE-GENERATED OUTPUT:  Adding resistors between ground and nodes with no DC path to ground:

RNODCPATH1 X_3:L2 0 1G
RNODCPATH2 X_3:N_2 0 1G
RNODCPATH3 VS1 0 1G
RNODCPATH4 X_3:H2 0 1G
RNODCPATH5 VS2 0 1G
RNODCPATH6 N_16 0 1G
RNODCPATH7 N_8 0 1G
RNODCPATH8 N_14 0 1G
RNODCPATH9 X_3:N_3 0 1G
RNODCPATH10 N_13 0 1G
RNODCPATH11 N_12 0 1G
RNODCPATH12 N_11 0 1G
RNODCPATH13 N_9 0 1G
RNODCPATH14 X_3:N_4 0 1G
RNODCPATH15 N_15 0 1G
RNODCPATH16 N_7 0 1G
RNODCPATH17 X_3:H1 0 1G
RNODCPATH18 N_10 0 1G
RNODCPATH19 X_3:L1 0 1G

.END
