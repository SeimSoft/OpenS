XYCE-generated Netlist file copy:  TIME='10:04:42 PM' DATE='Mar 19, 2026'
*Original Netlist Title:

** OpenS Generated Netlist

* Subcircuits
.subckt h_bridge GND P1 P2 VIN en_1_i en_2_i
.model DRIVER npy MODULE=controller_hbridge CLASS=Controller PYTHONPATH=/Users/rennekef/Documents/SchematicEntry/backup/tests/grid-tie/grid-tie-lib/h_bridge
.model BOOT_DIODE D (IS=1e-14 N=1 RS=0)
.model POWER_MOS NMOS (LEVEL=1 VTO=2.5 KP=0.5 LAMBDA=0.02 CGSO=100p CGDO=10p CBD=50p)
C1 BOOT1 N_1 1u
C2 BOOT2 P2 1u
C3 en_1_i GND 10p
C4 en_2_i GND 10p
D1 VIN BOOT1 BOOT_DIODE
D2 VIN BOOT2 BOOT_DIODE
M1 VIN H1 N_1 N_1 POWER_MOS L=1u W=10u m=1
M2 N_1 L1 GND GND POWER_MOS L=1u W=10u m=1
M3 VIN H2 P2 P2 POWER_MOS L=1u W=10u m=1
M4 P2 L2 GND GND POWER_MOS L=1u W=10u m=1
N1 VIN N_2 N_3 en_1_i en_2_i N_4 N_5 GND L1 L2 BOOT1 P2 N_1 BOOT2 H2 H1 DRIVER
V1 N_1 P1 dc 0 ac 0
.ends

* Main Circuit

*.preprocess addresistors nodcpath 1G
*Xyce:  ".PREPROCESS ADDRESISTORS" statement automatically commented out in netlist copy.
.model CONTROLLER npy MODULE=controller_llc CLASS=Controller PYTHONPATH=/Users/rennekef/Documents/SchematicEntry/backup/tests/grid-tie/grid-tie-lib/LLC
.model BOOTDIODE D (IS=1e-14 N=1 RS=0 CJO=1p M=0.5 TT=1n)
B1 Isoll N_2 V=LIMIT(V(N_3,REF_R_OUT)*1,-15,15)
B2 Iist N_2 V=LIMIT(V(I_out_meas,0)*1,-15,15)
C1 P1 N_6 1.818u IC=0
C3 0 T2 100n IC=0
C4 VZW T2 100n IC=0
C5 I_out_meas 0 10p
C6 N_3 REF_R_OUT 10n
D2 T1 VZW BOOTDIODE
D3 0 T1 BOOTDIODE
L1 N_6 int_1 1.393u IC=0
R1_ser int_1 N_7 0.1
L2 N1 int_2 1m IC=0
R2_ser int_2 VOUT 1
N1 VIN Iist Isoll N_9 N_10 Vclk N_11 Vmeas 0 N_5 N_4 en2 en1 N_12 N_13 N_14 CONTROLLER
R3 VIN N_8 0.1
R4 REF_R_OUT N2_2 640
R5 VZW Vmeas 1.596Meg
R6 Vmeas 0 4.4k
R7 I_out_meas 0 200
R8 VOUT N_3 1.6Meg
R9 N_3 REF_R_OUT 4.4k
* Skipping SCRIPT1: No template
LP1 N_7 P2 13.93u IC=0
LS1 T1 T2 619.2u IC=0
K1 LP1 LS1 0.99
LP2 N2_2 N2 2u IC=0
LS2 I_out_meas 0 20m IC=0
K2 LP2 LS2 0.9
V1 N_8 0 dc 30 ac 0
V2 VOUT REF_R_OUT dc 300 ac 0
V3 Vclk 0 PULSE(0 3.3 0 1n 1n {1/100k/2} {1/100k})
V4 N_2 0 dc 1.65 ac 0
V5 N_1 N_2 dc 1.65 ac 0
* Skipping VDD1: No template
X_1 0 P1 P2 VIN en1 en2 h_bridge
X_2 0 N1 N2 VZW N_4 N_5 h_bridge
.tran 1u 100u
.print tran v(*) i(C1) i(C3) i(C4) i(C5) i(C6) i(D2) i(D3) i(L1) i(L2) i(R3) i(R4) i(R5) i(R6) i(R7) i(R8) i(R9) i(V1) i(V2) i(V3)

*XYCE-GENERATED OUTPUT:  Adding resistors between ground and nodes connected to only 1 device terminal:

RONETERM1 X_1:N_5 0
RONETERM2 N_1 0
RONETERM3 X_1:N_3 0
RONETERM4 N_14 0
RONETERM5 X_2:N_3 0
RONETERM6 N_13 0
RONETERM7 X_1:N_2 0
RONETERM8 N_12 0
RONETERM9 X_1:N_4 0
RONETERM10 N_11 0
RONETERM11 N_10 0
RONETERM12 X_2:N_2 0
RONETERM13 N_9 0
RONETERM14 X_2:N_5 0
RONETERM15 X_2:N_4 0

*XYCE-GENERATED OUTPUT:  Adding resistors between ground and nodes with no DC path to ground:

RNODCPATH1 X_2:H2 0 1G
RNODCPATH2 N_4 0 1G
RNODCPATH3 X_2:L1 0 1G
RNODCPATH4 X_2:H1 0 1G
RNODCPATH5 X_1:H1 0 1G
RNODCPATH6 N_5 0 1G
RNODCPATH7 X_1:L2 0 1G
RNODCPATH8 EN2 0 1G
RNODCPATH9 X_2:L2 0 1G
RNODCPATH10 X_1:L1 0 1G
RNODCPATH11 EN1 0 1G
RNODCPATH12 X_1:H2 0 1G

.END
